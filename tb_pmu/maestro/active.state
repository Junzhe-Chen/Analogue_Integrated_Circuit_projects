ADE simulation setup
Test PMU_NOISE: analog_integrated_circuit_labs/tb_pmu/schematic, simulator spectre
  Models: /eda/cadence/pdk/gpdk180_v3.3/models/spectre/gpdk.scs[stat]
  Variables: c_load = 1p; r_load = 10k; v_dc = 2.5
  Temperature: 27
Test PMU_VSWEEP: analog_integrated_circuit_labs/tb_pmu/schematic, simulator spectre
  Models: /eda/cadence/pdk/gpdk180_v3.3/models/spectre/gpdk.scs[stat]
  Variables: c_load = 1f; r_load = 1G; v_dc = 2.5
  Temperature: 27
  Analysis dc: sweep v_dc start=2 stop=2.5 lin=10
  Signals: /VOUT as output_voltage_vsweep
Test PMU_ISWEEP: analog_integrated_circuit_labs/tb_pmu/schematic, simulator spectre
  Models: /eda/cadence/pdk/gpdk180_v3.3/models/spectre/gpdk.scs[stat]
  Variables: c_load = 1p; r_load = 1k; v_dc = 2.5
  Temperature: 27
  Analysis dc: sweep r_load start=900 stop=18000 dec=8
  Signals: /VOUT as output_voltage_isweep, /R0/PLUS (terminal) as load_current
Test PMU_STATIC_CURRENT: analog_integrated_circuit_labs/tb_pmu/schematic, simulator spectre
  Models: /eda/cadence/pdk/gpdk180_v3.3/models/spectre/gpdk.scs[stat]
  Variables: c_load = 1f; r_load = 1G; v_dc = 2.5
  Temperature: 27
  Signals: /I0/BGR/VDD (terminal) as bandgap_Iq, /I0/LDO/VDD (terminal) as LDO_Iq
Test BGR_TEMP: analog_integrated_circuit_labs/tb_pmu/schematic, simulator spectre
  Models: /eda/cadence/pdk/gpdk180_v3.3/models/spectre/gpdk.scs[stat]
  Variables: c_load = 1f; r_load = 10k; v_dc = 2.5
  Temperature: 27
  Analysis dc: sweep temperature start=0 stop=75
  Signals: /I0/VBG as ref_voltage
Test PMU_PSRR: analog_integrated_circuit_labs/tb_pmu/schematic, simulator spectre
  Models: /eda/cadence/pdk/gpdk180_v3.3/models/spectre/gpdk.scs[stat]
  Variables: c_load = 1p; r_load = 10k; v_dc = 2.5
  Temperature: 27
  Analysis ac: start=1 stop=1M
  Signals: /VOUT as PSRR_LDO_out, /I0/VBG as PSRR_BGR_out
Run mode: Single Run, Sweeps and Corners
