ADE simulation setup
Run mode: Single Run, Sweeps and Corners
Tests:
  PMU_VSWEEP: analog_integrated_circuit_labs/tb_pmu/schematic, simulator spectre
    Variables: c_load = 1f; r_load = 1G; v_dc = 2.5
  PMU_ISWEEP: analog_integrated_circuit_labs/tb_pmu/schematic, simulator spectre
    Variables: c_load = 1p; r_load = 1k; v_dc = 2.5
  PMU_STATIC_CURRENT: analog_integrated_circuit_labs/tb_pmu/schematic, simulator spectre
    Variables: c_load = 1f; r_load = 1G; v_dc = 2.5
    Outputs: bandgap_Iq; LDO_Iq
  BGR_TEMP: analog_integrated_circuit_labs/tb_pmu/schematic, simulator spectre
    Variables: c_load = 1f; r_load = 10k; v_dc = 2.5
  PMU_PSRR: analog_integrated_circuit_labs/tb_pmu/schematic, simulator spectre
    Variables: c_load = 1p; r_load = 10k; v_dc = 2.5
  PMU_NOISE: analog_integrated_circuit_labs/tb_pmu/schematic, simulator spectre
    Variables: c_load = 1p; r_load = 10k; v_dc = 2.5
